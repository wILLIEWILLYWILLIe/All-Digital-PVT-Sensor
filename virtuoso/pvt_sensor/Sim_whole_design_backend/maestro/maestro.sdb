ADE simulation setup
Run mode: Single Run, Sweeps and Corners
Tests:
  pvt_sensor_Sim_whole_design_backend_1: pvt_sensor/Sim_whole_design_backend/config, simulator spectre
    Variables: vdd = 1; var_f = 100e6; var_tau = 20e-9
