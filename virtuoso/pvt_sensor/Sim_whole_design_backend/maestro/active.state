ADE simulation setup
Test pvt_sensor_Sim_whole_design_backend_1: pvt_sensor/Sim_whole_design_backend/config, simulator spectre
  Models: /vol/eecs391/GPDK045/gpdk045_v_6_0/gpdk045/../models/spectre/gpdk045.scs[mc]
  Variables: vdd = 1; var_f = 100e6; var_tau = 10e-9
  Temperature: 27
  Analysis tran: stop=80n errpreset=moderate
  Output Max Device Temp = (etaMaxTrise() + VAR("temp")) (unticked)
  Output Min Device Temp = (etaMinTrise() + VAR("temp")) (unticked)
  Output TotalPwr = etaTotalPwr()
  Output MaxGridTemp = (etaMaxGridTrise() + VAR("temp")) (unticked)
  Output MinGridTemp = (etaMinGridTrise() + VAR("temp")) (unticked)
  Signals: /VDD!, /rst_n, /clk, /clk_delay, /clk_leaf, /is_error_root, /is_error_leaf, /I7/leaf/ref1, /I7/leaf/data1, /I7/leaf/data0, /I7/leaf/trc1_in, /I7/leaf/trc1_out, /I7/leaf/net4, /I7/leaf/net13
Run mode: Single Run, Sweeps and Corners
