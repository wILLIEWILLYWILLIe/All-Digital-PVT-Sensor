ADE simulation setup
Test pvt_sensor_TB_TLD_1: pvt_sensor/TB_TLD/config, simulator spectre
  Models: /vol/eecs391/GPDK045/gpdk045_v_6_0/gpdk045/../models/spectre/gpdk045.scs[mc]
  Variables: vdd = 1
  Temperature: 27
  Analysis tran: stop=40n
  Output v("/out8" ?result "tran")
  Output v("/out4" ?result "tran")
  Output v("/out2" ?result "tran")
  Output v("/net1" ?result "tran")
  Output v("/out" ?result "tran")
  Signals: /net1, /I6/dbg_out2 (terminal), /I6/dbg_out4 (terminal), /I6/dbg_out8 (terminal), /out, /out8, /out4, /out2
Run mode: Single Run, Sweeps and Corners
