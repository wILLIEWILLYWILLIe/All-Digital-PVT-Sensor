ADE simulation setup
Run mode: Single Run, Sweeps and Corners
Tests:
  pvt_sensor_TB_TLD_1: pvt_sensor/TB_TLD/config, simulator spectre
    Variables: vdd = 1
