ADE simulation setup
Test pvt_sensor_Sim_whole_design_1: pvt_sensor/Sim_whole_design/schematic, simulator spectre
  Models: /vol/eecs391/GPDK045/gpdk045_v_6_0/gpdk045/../models/spectre/gpdk045.scs[mc]
  Variables: vdd = 1.0; var_f = 333e6
  Temperature: 27
  Analysis tran: stop=50n errpreset=moderate
  Signals: /VDD!, /rst_n, /clk as clk_root, /clk_delay, /clk_leaf, /is_error_root as error_root, /is_error_leaf as error_leaf, /I0/leaf/ref1, /I0/leaf/data1, /I0/leaf/data0
Run mode: Single Run, Sweeps and Corners
