ADE simulation setup
Run mode: Single Run, Sweeps and Corners
Tests:
  pvt_sensor_Sim_whole_design_1: pvt_sensor/Sim_whole_design/schematic, simulator spectre
    Variables: var_f = 333e6; vdd = 1.0
