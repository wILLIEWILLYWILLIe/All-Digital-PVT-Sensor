ADE simulation setup
Run mode: Single Run, Sweeps and Corners
Tests:
  pvt_sensor_Sim_mux16_1: pvt_sensor/Sim_mux16/schematic, simulator spectre
    Variables: vdd = 1.0
