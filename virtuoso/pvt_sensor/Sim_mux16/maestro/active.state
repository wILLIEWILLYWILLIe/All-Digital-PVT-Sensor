ADE simulation setup
Test pvt_sensor_Sim_mux16_1: pvt_sensor/Sim_mux16/schematic, simulator spectre
  Models: /vol/eecs391/GPDK045/gpdk045_v_6_0/gpdk045/../models/spectre/gpdk045.scs[mc]
  Variables: vdd = 1.0
  Temperature: 27
  Analysis tran: stop=50n errpreset=moderate
  Signals: /zero, /test_one, /out, /out2, /I0/net4, /I0/net11, /I0/net18, /I0/net25
Run mode: Single Run, Sweeps and Corners
