ADE simulation setup
Run mode: Single Run, Sweeps and Corners
Tests:
  pvt_sensor_Sim_dvm_jzh_1: pvt_sensor/Sim_dvm_jzh/config, simulator spectre
    Variables: vdd = 1; var_f = 100e6
