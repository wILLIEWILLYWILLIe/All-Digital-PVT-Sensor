ADE simulation setup
Test pvt_sensor_Sim_dvm_jzh_1: pvt_sensor/Sim_dvm_jzh/config, simulator spectre
  Models: /vol/eecs391/GPDK045/gpdk045_v_6_0/gpdk045/../models/spectre/gpdk045.scs[mc]
  Variables: vdd = 1; var_f = 100e6
  Temperature: 27
  Analysis tran: stop=50n errpreset=moderate
  Signals: /VDD!, /rst_n, /clk, /out, /I0/ref1, /I0/data1, /I0/data0, /I0/trc1_in, /I0/trc1_out, /I0/net4, /I0/net13
Run mode: Single Run, Sweeps and Corners
