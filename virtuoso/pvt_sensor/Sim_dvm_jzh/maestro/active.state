ADE simulation setup
Test pvt_sensor_Sim_dvm_jzh_1: pvt_sensor/Sim_dvm_jzh/schematic, simulator spectre
  Models: /vol/eecs391/GPDK045/gpdk045_v_6_0/gpdk045/../models/spectre/gpdk045.scs[mc]
  Variables: vdd = 1.0
  Temperature: 27
  Stimulus rst_n: voltage pulse dc=0 val0=1 val1=0 period=1 delay=2n rise=20p fall=20p width=5n srcType=pulse
  Stimulus VDD!: voltage pulse dc=1 val0=1 val1=900.0m period=1 delay=10n rise=20p fall=20p width=500.0m srcType=pulse
  Stimulus VSS!: voltage dc dc=0 srcType=dc
  Analysis tran: stop=50n errpreset=moderate
  Signals: /VDD!, /out, /clk, /rst_n, /I0/ref1, /I0/data1, /I0/data0, /zero, /I0/trc1_in, /I0/trc1_out, /vdd_droop
Run mode: Single Run, Sweeps and Corners
