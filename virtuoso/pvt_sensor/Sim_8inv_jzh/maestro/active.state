ADE simulation setup
Test pvt_sensor_Sim_8inv_jzh_1: pvt_sensor/Sim_8inv_jzh/schematic, simulator spectre
  Models: /vol/eecs391/GPDK045/gpdk045_v_6_0/gpdk045/../models/spectre/gpdk045.scs[mc]
  Variables: vdd = 1.0
  Temperature: 27
  Analysis tran: stop=50n errpreset=moderate
  Signals: /net1, /out, /VSS!, /VDD!
Run mode: Single Run, Sweeps and Corners
