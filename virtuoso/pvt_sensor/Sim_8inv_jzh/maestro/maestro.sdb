ADE simulation setup
Run mode: Single Run, Sweeps and Corners
Tests:
  pvt_sensor_Sim_8inv_jzh_1: pvt_sensor/Sim_8inv_jzh/schematic, simulator spectre
    Variables: vdd = 1.0
