ADE simulation setup
Run mode: Single Run, Sweeps and Corners
Tests:
  pvt_sensor_Sim_trc_jzh_1: pvt_sensor/Sim_trc_jzh/config, simulator spectre
    Variables: vdd = 1; var_f = 50e6
