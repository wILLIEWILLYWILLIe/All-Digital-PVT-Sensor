ADE simulation setup
Test pvt_sensor_Sim_trc_jzh_1: pvt_sensor/Sim_trc_jzh/config, simulator spectre
  Models: /vol/eecs391/GPDK045/gpdk045_v_6_0/gpdk045/../models/spectre/gpdk045.scs[mc]
  Variables: vdd = 1; var_f = 50e6
  Temperature: 27
  Analysis tran: stop=50n errpreset=moderate
  Signals: /VDD!, /test_one, /trc_out
Run mode: Single Run, Sweeps and Corners
