ADE simulation setup
Run mode: Single Run, Sweeps and Corners
Tests:
  pvt_sensor_Sim_clk_gate_jzh_1: pvt_sensor/Sim_clk_gate_jzh/schematic, simulator spectre
