ADE simulation setup
Test pvt_sensor_Sim_clk_gate_jzh_1: pvt_sensor/Sim_clk_gate_jzh/schematic, simulator spectre
  Models: /vol/eecs391/GPDK045/gpdk045_v_6_0/gpdk045/../models/spectre/gpdk045.scs[mc]
  Temperature: 27
  Stimulus is_error: voltage pwl pwlfilter=  abstime=  tvpairs=17 t1=0 v1=0 t2=15n v2=0 t3=15.01n v3=1 t4=17n v4=1 t5=17.01n v5=0 t6=18n v6=0 t7=18.01n v7=1 t8=19n v8=1 t9=19.01n v9=0 t10=22n v10=0 t11=22.01n v11=1 t12=23n v12=1 t13=23.01n v13=0 t14=33n v14=0 t15=33.01n v15=1 t16=34n v16=1 t17=34.01n v17=0 v18=0 v19=0 v20=0 v21=0 v22=0 v23=0 v24=0 v25=0 v26=0 v27=0 v28=0 v29=0 v30=0 v31=0 v32=0 v33=0 v34=0 v35=0 v36=0 v37=0 v38=0 v39=0 v40=0 v41=0 v42=0 v43=0 v44=0 v45=0 v46=0 v47=0 v48=0 v49=0 v50=0 srcType=pwl
  Analysis tran: stop=50n errpreset=moderate
  Signals: /clk, /rst_n, /is_error, /I0/clk_en, /clk_leaf, /I0/I20/Eint as cig_en, /I0/I20/CKbb as cig_clk
Run mode: Single Run, Sweeps and Corners
