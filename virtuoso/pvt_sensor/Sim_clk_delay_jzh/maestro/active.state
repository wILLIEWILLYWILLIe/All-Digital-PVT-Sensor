ADE simulation setup
Test pvt_sensor_Sim_clk_delay_jzh_1: pvt_sensor/Sim_clk_delay_jzh/schematic, simulator spectre
  Models: /vol/eecs391/GPDK045/gpdk045_v_6_0/gpdk045/../models/spectre/gpdk045.scs[mc]
  Variables: var_f = 200e6; vdd = 1.0
  Temperature: 27
  Stimulus rst_n: voltage pulse dc=0 val0=1 val1=0 period=1 delay=10p rise=5p fall=5p width=7n srcType=pulse
  Stimulus clk_root: voltage pulse dc=0 val0=1 val1=0 period=1n delay=200.0p rise=5p fall=5p width=500.0p srcType=pulse
  Stimulus VSS!: voltage dc dc=0 srcType=dc
  Stimulus VDD!: voltage pulse dc=1 val0=1 val1=900.0m period=1 delay=10n rise=5p fall=5p width=500.0m srcType=pulse
  Analysis tran: stop=50n errpreset=moderate
  Signals: /VDD!, /clk_root, /delay_clk, /rst_n, /is_error_root, /is_error_leaf
Run mode: Single Run, Sweeps and Corners
