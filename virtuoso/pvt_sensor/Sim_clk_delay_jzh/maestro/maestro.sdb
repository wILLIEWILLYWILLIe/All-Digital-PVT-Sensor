ADE simulation setup
Run mode: Single Run, Sweeps and Corners
Tests:
  pvt_sensor_Sim_clk_delay_jzh_1: pvt_sensor/Sim_clk_delay_jzh/schematic, simulator spectre
    Variables: vdd = 1.0; var_f = 200e6; var_tau = 10e-9
