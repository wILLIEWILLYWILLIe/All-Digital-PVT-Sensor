ADE simulation setup
Test pvt_sensor_Sim_tunable_delay_backend_1: pvt_sensor/Sim_tunable_delay_backend/config, simulator spectre
  Models: /vol/eecs391/GPDK045/gpdk045_v_6_0/gpdk045/../models/spectre/gpdk045.scs[mc]
  Variables: vdd = 1; var_f = 100e6
  Temperature: 27
  Analysis tran: stop=50n errpreset=moderate
  Signals: /VDD!, /clk_in, /clk_delay
Run mode: Single Run, Sweeps and Corners
