ADE simulation setup
Test pvt_sensor_TB_1: pvt_sensor/TB_delay/config, simulator spectre
  Models: /vol/eecs391/GPDK045/gpdk045_v_6_0/gpdk045/../models/spectre/gpdk045.scs[mc]
  Variables: vdd = 1.0
  Temperature: 27
  Analysis tran: stop=5n errpreset=moderate
  Signals: /net1, /net2, /out
Run mode: Single Run, Sweeps and Corners
