ADE simulation setup
Run mode: Single Run, Sweeps and Corners
Tests:
  pvt_sensor_TB_1: pvt_sensor/TB_delay/config, simulator spectre
    Variables: vdd = 1.0
