ADE simulation setup
Run mode: Single Run, Sweeps and Corners
Tests:
  pvt_sensor_tunable_delay_gel_1: pvt_sensor/tunable_delay_gel/physConfig, simulator spectre
