ADE simulation setup
Test pvt_sensor_tunable_delay_gel_1: pvt_sensor/tunable_delay_gel/physConfig, simulator spectre
  Models: /vol/eecs391/GPDK045/gpdk045_v_6_0/gpdk045/../models/spectre/gpdk045.scs[mc]
  Temperature: 27
Run mode: Single Run, Sweeps and Corners
