ADE simulation setup
Run mode: Single Run, Sweeps and Corners
Tests:
  pvt_sensor_Sim_dvm_droop_jzh_1: pvt_sensor/Sim_dvm_droop_jzh/schematic, simulator spectre
    Variables: vdd = 1.0; var_f = 100E6
