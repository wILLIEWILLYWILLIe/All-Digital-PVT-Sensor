ADE simulation setup
Test pvt_sensor_Sim_dvm_droop_jzh_1: pvt_sensor/Sim_dvm_droop_jzh/schematic, simulator spectre
  Models: /vol/eecs391/GPDK045/gpdk045_v_6_0/gpdk045/../models/spectre/gpdk045.scs[mc]
  Variables: var_f = 100E6; vdd = 1.0
  Temperature: 27
  Analysis tran: stop=50n errpreset=moderate
  Signals: /VDD!, /out, /clk, /rst_n, /I0/ref1, /I0/data1, /I0/data0, /zero, /I0/trc1_in, /I0/trc1_out
Run mode: Single Run, Sweeps and Corners
